ADE simulation setup
Test edtest00_SIM_cpreg_tran_1: edtest00/SIM_cpreg_tran/schematic, simulator spectre
  Models: /afs/ee.ust.hk/sun4x_56/usr/eelocal/tsmc_icdc/tsmc028/28HPCplus_RF/PDK/TSMC_iPDK/tn28crsp029w1_1_8_2p2a/SkillPc_RF_0p9_1p8_1P9M_6X1Z1U_UT_AlRDL_ind1z1u/tsmcN28/../models/spectre/toplevel.scs[TOP_TT]
  Variables: ib1u = 0.25u; vdd1p8 = 1.8; vref = 0.5
  Temperature: 27
  Analysis pstb: start=1 stop=1e9 fund=3M probe=/V3
  Analysis pss: engine=Shooting fund=3M harms=9 tstab=200u errpreset=conservative
  Signals: /v0p9, /vgg
Run mode: Single Run, Sweeps and Corners
