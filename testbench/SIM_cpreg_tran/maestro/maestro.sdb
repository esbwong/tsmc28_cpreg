ADE simulation setup
Run mode: Single Run, Sweeps and Corners
Tests:
  edtest00_SIM_cpreg_tran_1: edtest00/SIM_cpreg_tran/schematic, simulator spectre
    Variables: ib1u = 0.25u; vdd1p8 = 1.8; vref = 0.5
